# Ansys Electronics Desktop project, version 2024.2
materials:
  vacuum: permittivity=1
  Rogers RO4003 (tm): permittivity=3.55 dielectric_loss_tangent=0.0027
  copper: permeability=0.999991 conductivity=58000000
  skin: permittivity=30
  fat: permittivity=5.5
  bone: permittivity=20
  nail: permittivity=3
  blood_72: permittivity=60.47 conductivity=2.45
  blood_95: permittivity=59.74 conductivity=2.45
  blood_134: permittivity=58.57 conductivity=2.3
  blood_163: permittivity=57.78 conductivity=2.3
  blood_296: permittivity=53.83 conductivity=2.15
  blood_313: permittivity=53.3 conductivity=2.15

design HFSSDesign1 (HFSS, HFSS Terminal Network, model units mm)
variables:
  Rs = 6mm
  d = 0.5mm
geometry:
  Ground_Plate = rectangle(corner=(-20mm, -15mm, 0mm), x_size=70mm, y_size=70mm)
  Substrate [Rogers RO4003 (tm)] = box(corner=(-20mm, -15mm, 0mm), size=(70mm, 70mm, 0.508mm))
  Circle1 = circle(normal=Z, centre=(15mm, 20mm, 0.508mm), radius=20.5mm)
  Circle2 = circle(normal=Z, centre=(15mm, 20mm, 0.508mm), radius=7mm)
  Circle1.subtract(Circle2)
  Circle3 = circle(normal=Z, centre=(15mm, 20mm, 0.508mm), radius=Rs)
  Rectangle1 = rectangle(corner=(15mm, 20mm, 0.508mm), x_size=6mm, y_size=7mm)
  Rectangle2 = rectangle(corner=(15mm, 20mm, 0.508mm), x_size=8mm, y_size=4mm)
  Rectangle3 = rectangle(corner=(15mm, 20mm, 0.508mm), x_size=-6mm, y_size=-7mm)
  Rectangle4 = rectangle(corner=(15mm, 20mm, 0.508mm), x_size=-8mm, y_size=-4mm)
  Circle3.unite(Circle1, Rectangle4, Rectangle3, Rectangle2, Rectangle1)
  Circle3.move(-15mm, -20mm, 0mm)
  Circle3.rotate(axis=Z, angle=45deg)
  Circle3.move(15mm, 20mm, 0mm)
  Polyline1 = polyline(z=0.508mm, xy in mm: (13.6, 10.6) (14, 13.6) (14.1, 13.6) (13.7, 10.6) (13.6, 10.6), closed, covered)
  Polyline2 = polyline(z=0.508mm, xy in mm: (16.4, 10.6) (16, 13.6) (15.9, 13.6) (16.3, 10.6) (16.4, 10.6), closed, covered)
  Circle3.subtract(Polyline1, Polyline2)
  Rectangle7 = rectangle(corner=(13.7mm, 10.6mm, 0.508mm), x_size=-0.08mm, y_size=-0.01mm)
  Circle3.subtract(Rectangle7)
  Rectangle8 = rectangle(corner=(16.3mm, 10.6mm, 0.508mm), x_size=0.08mm, y_size=-0.01mm)
  Circle3.subtract(Rectangle8)
  Rectangle9 = rectangle(corner=(15.9mm, 10.4mm, 0.508mm), x_size=14.1mm, y_size=-1.1mm)
  Rectangle10 = rectangle(corner=(15.9mm, 10.4mm, 0.508mm), x_size=-15.9mm, y_size=-1.1mm)
  Rectangle10.unite(Rectangle9)
  Rectangle11 = rectangle(corner=(13.695431mm, 10.59mm, 0.508mm), x_size=2.6045689mm, y_size=-1.29mm)
  Rectangle11.unite(Rectangle10)
  Rectangle11.unite(Circle3)
  Polygon1 = regular_polygon(axis=Z, centre=(15mm, 20mm, 0.508mm), first_corner=(19mm, 20mm, 0.508mm), sides=6)
  Rectangle11.subtract(Polygon1)
  Polyline26 [vacuum] = imported_body()
  Cylinder1 [copper] = cylinder(axis=Z, base_centre=(15mm, 28.25mm, 0.508mm), radius=d, height=-0.508mm)
  Cylinder2 [copper] = cylinder(axis=Z, base_centre=(23.25mm, 20mm, 0.508mm), radius=d, height=-0.508mm)
  Cylinder3 [copper] = cylinder(axis=Z, base_centre=(6.75mm, 20mm, 0.508mm), radius=d, height=-0.508mm)
  Cylinder4 [copper] = cylinder(axis=Z, base_centre=(7.567mm, 16.4205mm, 0.508mm), radius=d, height=-0.508mm)
  Cylinder5 [copper] = cylinder(axis=Z, base_centre=(22.433mm, 16.4205mm, 0.508mm), radius=d, height=-0.508mm)
  Cylinder6 [copper] = cylinder(axis=Z, base_centre=(23.0432mm, 18.1642mm, 0.508mm), radius=d, height=-0.508mm)
  Cylinder7 [copper] = cylinder(axis=Z, base_centre=(6.9568mm, 18.1642mm, 0.508mm), radius=d, height=-0.508mm)
  Cylinder8 [copper] = cylinder(axis=Z, base_centre=(23.0432mm, 21.8358mm, 0.508mm), radius=d, height=-0.508mm)
  Cylinder9 [copper] = cylinder(axis=Z, base_centre=(6.9568mm, 21.8358mm, 0.508mm), radius=d, height=-0.508mm)
  Cylinder10 [copper] = cylinder(axis=Z, base_centre=(22.433mm, 23.5795mm, 0.508mm), radius=d, height=-0.508mm)
  Cylinder11 [copper] = cylinder(axis=Z, base_centre=(7.567mm, 23.5795mm, 0.508mm), radius=d, height=-0.508mm)
  Cylinder12 [copper] = cylinder(axis=Z, base_centre=(21.4501mm, 25.1438mm, 0.508mm), radius=d, height=-0.508mm)
  Cylinder13 [copper] = cylinder(axis=Z, base_centre=(8.5499mm, 25.1438mm, 0.508mm), radius=d, height=-0.508mm)
  Cylinder14 [copper] = cylinder(axis=Z, base_centre=(20.1438mm, 26.4501mm, 0.508mm), radius=d, height=-0.508mm)
  Cylinder15 [copper] = cylinder(axis=Z, base_centre=(9.8562mm, 26.4501mm, 0.508mm), radius=d, height=-0.508mm)
  Cylinder16 [copper] = cylinder(axis=Z, base_centre=(18.5795mm, 27.433mm, 0.508mm), radius=d, height=-0.508mm)
  Cylinder17 [copper] = cylinder(axis=Z, base_centre=(11.4205mm, 27.433mm, 0.508mm), radius=d, height=-0.508mm)
  Cylinder18 [copper] = cylinder(axis=Z, base_centre=(16.8358mm, 28.0432mm, 0.508mm), radius=d, height=-0.508mm)
  Cylinder19 [copper] = cylinder(axis=Z, base_centre=(13.1642mm, 28.0432mm, 0.508mm), radius=d, height=-0.508mm)
  Polyline26.unite(Rectangle11)
  Box1 [vacuum] = box(corner=(-25mm, -20mm, -30mm), size=(80mm, 80mm, 50mm))
  Polyline27 = polyline(z=0.508mm, xy in mm: (13, 16.535898) (11, 20) (13, 23.464102) (17, 23.464102) (19, 20) (17, 16.535898) (13, 16.535898), closed, covered)
  Polyline26.subtract(Polyline27)
  Polyline28 = polyline(z=0.508mm, xy in mm: (13, 16.535898) (11, 20) (13, 23.5) (17, 23.464102) (19, 20) (17, 16.535898) (13, 16.535898), closed, covered)
  Polyline26.unite(Polyline28)
  Circle4 = circle(normal=Z, centre=(15mm, 20mm, 0.508mm), radius=5mm)
  Circle5 = circle(normal=Z, centre=(15mm, 20mm, 0.508mm), radius=4.5mm)
  Circle6 = circle(normal=Z, centre=(15mm, 20mm, 0.508mm), radius=4mm)
  Circle7 = circle(normal=Z, centre=(15mm, 20mm, 0.508mm), radius=3.5mm)
  Polyline26.subtract(Circle4)
  Polyline26.unite(Circle5)
  Polyline26.subtract(Circle6)
  Polyline26.unite(Circle7)
  Polyline29 = polyline(z=0.508mm, xy in mm: (15, 16) (16, 16) (16, 16.8) (14, 16.8) (14, 16) (15, 16), closed, covered)
  Polyline26.unite(Polyline29)
  Polyline30 = polyline(z=0.508mm, xy in mm: (15, 24) (16, 24) (16, 25) (14, 25) (14, 24) (15, 24), closed, covered)
  Polyline26.unite(Polyline30)
  Polyline31 = polyline(z=0.508mm, xy in mm: (30, 10.4) (32.5, 10.4) (32.5, 9.3) (-2.5, 9.3) (-2.5, 10.4) (30, 10.4), closed, covered)
  Polyline26.unite(Polyline31)
  Polyline32 = polyline(z=0.508mm, xy in mm: (-2.5, 10.4) (32.5, 10.4) (32.5, 9.3) (-2.5, 9.3) (-2.5, 10.4), closed, covered)
  Polyline26.subtract(Polyline32)
  Rectangle12 = rectangle(corner=(-2.5mm, 9.3mm, 0.508mm), x_size=36.5mm, y_size=4.7mm)
  Polyline26.unite(Rectangle12)
  Polyline34 = polyline(z=0.508mm, xy in mm: (15, -5) (-20, -5) (-20, -8) (50, -8) (50, -5) (15, -5), closed, covered)
  Polyline36 = polyline(z=0.508mm, xy in mm: (19, -5) (17, 4) (16.7, 4) (18.7, -5) (19, -5), closed, covered)
  Polyline26.subtract(Polyline36)
  Polyline38 = polyline(z=0.508mm, xy in mm: (12.5, 4) (12.2, 4) (10.8, -5) (11, -5) (12.5, 4), closed, covered)
  Polyline26.subtract(Polyline38)
  Polyline39 = polyline(z=0.508mm, xy in mm: (11.052276, -4.6863419) (18.640772, -4.7334748) (18.640772, -8) (11, -8) (11.052276, -4.6863419), closed, covered)
  Polyline26.unite(Polyline34, Polyline39)
  Circle8 = circle(normal=Z, centre=(15mm, 20mm, 0.508mm), radius=5mm)
  Polyline26.subtract(Circle8)
  Cylinder1.move(0mm, 8.75mm, 0mm)
  Cylinder2.move(8.75mm, 0mm, 0mm)
  Cylinder3.move(-8.75mm, 0mm, 0mm)
  Cylinder4.move(-7.567mm, -4.4205mm, 0mm)
  Cylinder5.move(7.567mm, -4.4205mm, 0mm)
  Cylinder6.move(8.4568mm, -2.1642mm, 0mm)
  Cylinder8.move(8.4568mm, 2.1642mm, 0mm)
  Cylinder10.move(7.567mm, 4.4205mm, 0mm)
  Cylinder12.move(6.0499mm, 6.3562mm, 0mm)
  Cylinder14.move(3.8562mm, 8.0499mm, 0mm)
  Cylinder16.move(2.4205mm, 8.567mm, 0mm)
  Cylinder18.move(0.9892mm, 8.9568mm, 0mm)
  Cylinder7.move(-8.4568mm, -2.1642mm, 0mm)
  Cylinder9.move(-8.4568mm, 2.1642mm, 0mm)
  Cylinder11.move(-8.067mm, 3.9205mm, 0mm)
  Cylinder13.move(-7.0499mm, 5.3562mm, 0mm)
  Cylinder15.move(-5.5312mm, 7.0499mm, 0mm)
  Cylinder17.move(-3.4205mm, 8.067mm, 0mm)
  Cylinder19.move(-1.6642mm, 8.4568mm, 0mm)
  Polyline40 = polyline(z=0.508mm, xy in mm: (18.640772, -4.7334748) (11.052276, -4.6863419) (11.381082, -2.7135077) (18.205668, -2.7755064) (18.640772, -4.7334748), closed, covered)
  Polyline26.unite(Polyline40)
  Circle9 = circle(normal=Z, centre=(15mm, 20mm, 0.508mm), radius=7mm)
  Polyline26.unite(Circle9)
  Circle10 = circle(normal=Z, centre=(15mm, 20mm, 0.508mm), radius=14mm)
  Circle11 = circle(normal=Z, centre=(15mm, 20mm, 0.508mm), radius=12.041595mm)
  Polyline26.subtract(Circle10)
  Polyline26.unite(Circle11)
  Polyline41 = polyline(z=0.508mm, xy in mm: (15, 20) (11.5, 16.5) (1, 6) (29, 6) (15, 20), closed, covered)
  Polyline42 = polyline(z=0.508mm, xy in mm: (15, 20) (3, 32) (27, 32) (15, 20), closed, covered)
  Polyline26.unite(Polyline41, Polyline42)
  Polyline43 = polyline(z=0.508mm, xy in mm: (7.7888974, 32) (8, 30) (22.211103, 32) (18, 36) (8, 34) (7.7888974, 32), closed, covered)
  Polyline26.unite(Polyline43)
  Circle12 = circle(normal=Z, centre=(15mm, 20mm, 0.508mm), radius=9mm)
  Circle13 = circle(normal=Z, centre=(15mm, 20mm, 0.508mm), radius=8mm)
  Circle14 = circle(normal=Z, centre=(15mm, 20mm, 0.508mm), radius=6mm)
  Circle15 = circle(normal=Z, centre=(15mm, 20mm, 0.508mm), radius=5mm)
  Polyline26.subtract(Circle12)
  Polyline26.unite(Circle13)
  Polyline26.subtract(Circle14)
  Polyline26.unite(Circle15)
  Polyline44 = polyline(z=0.508mm, xy in mm: (15, 14) (17, 14) (17, 16) (13, 16) (13, 14) (15, 14), closed, covered)
  Polyline26.unite(Polyline44)
  Polyline45 = polyline(z=0.508mm, xy in mm: (15, 29) (17, 29) (17, 27) (13, 27) (13, 29) (15, 29), closed, covered)
  Polyline26.unite(Polyline45)
  Polyline46 = polyline(z=0.508mm, xy in mm: (11.381082, -2.7135077) (11.463284, -2.2202979) (18.096857, -2.2858582) (18.205668, -2.7755064) (11.381082, -2.7135077), closed, covered)
  Polyline26.unite(Polyline46)
  Polyline47 = polyline(z=0.508mm, xy in mm: (11.463284, -2.2202979) (11.627687, -1.2338764) (17.879187, -1.3063436) (18.096857, -2.2858582) (11.463284, -2.2202979), closed, covered)
  Polyline26.unite(Polyline47)
  Polyline48 = polyline(z=0.508mm, xy in mm: (50, -5) (50, -4) (-20, -4) (-20, -5) (50, -5), closed, covered)
  Polyline49 = polyline(z=0.508mm, xy in mm: (-20, -8) (-20, -7) (50, -7) (50, -8) (-20, -8), closed, covered)
  Polyline26.subtract(Polyline49)
  Polyline26.unite(Polyline48)
  Polyline50 = polyline(z=0.508mm, xy in mm: (17.661445, -0.32650266) (17.879187, -1.3063436) (11.627687, -1.2338764) (11.792091, -0.24745223) (17.661445, -0.32650266), closed, covered)
  Polyline26.unite(Polyline50)
  Polyline51 = polyline(z=0.508mm, xy in mm: (32.485994, 9.3) (34, 12.302598) (34, 9.3) (32.485994, 9.3), closed, covered)
  Polyline26.subtract(Polyline51)
  Polyline52 = polyline(z=0.508mm, xy in mm: (50, -4) (-20, -4) (-20, -1) (50, -1) (50, -4), closed, covered)
  Polyline53 = polyline(z=0.508mm, xy in mm: (-20, -4) (50, -4) (50, -7) (-20, -7) (-20, -4), closed, covered)
  Polyline26.subtract(Polyline53)
  Polyline26.unite(Polyline52)
  Rectangle13 = rectangle(corner=(-20mm, -4mm, 0.508mm), y_size=-3mm, z_size=-0.508mm)
  Rectangle14 = rectangle(corner=(50mm, -4mm, 0.508mm), y_size=-3mm, z_size=-0.508mm)
  Polyline54 = polyline(z=0.508mm, xy in mm: (50, -4) (50, -7) (-20, -7) (-20, -4) (50, -4), closed, covered)
  Polyline55 = polyline(z=0.508mm, xy in mm: (-20, -4) (-20, -1) (50, -1) (50, -4) (-20, -4), closed, covered)
  Polyline26.subtract(Polyline55)
  Polyline56 = polyline(z=0.508mm, xy in mm: (12.5, 4) (11.666667, -1) (11.2, -4.2) (18.5, -4.2) (16.7, 4) (12.5, 4), closed, covered)
  Polyline26.unite(Polyline54, Polyline56)
  bottom_skin [skin] = box(corner=(7.5mm, 7.5mm, 0.508mm), size=(15mm, 25mm, 1mm))
  bottom_fat [fat] = box(corner=(7.5mm, 32.5mm, 1.508mm), size=(15mm, -25mm, 0.5mm))
  bottom_blood [blood_163] = box(corner=(7.5mm, 32.5mm, 2.008mm), size=(15mm, -25mm, 2.5mm))
  bone_layer [bone] = box(corner=(7.5mm, 32.5mm, 4.508mm), size=(15mm, -25mm, 4mm))
  top_blood [blood_163] = box(corner=(7.5mm, 32.5mm, 8.508mm), size=(15mm, -25mm, 2.5mm))
  top_fat [fat] = box(corner=(7.5mm, 32.5mm, 11.008mm), size=(15mm, -25mm, 0.5mm))
  top_skin [skin] = box(corner=(7.5mm, 32.5mm, 11.508mm), size=(15mm, -25mm, 1mm))
  nail_layer [nail] = box(corner=(7.5mm, 32.5mm, 12.508mm), size=(15mm, -12.5mm, 0.3mm))
boundaries and excitations:
  FiniteCond1: Finite Conductivity Objects=Polyline26 UseMaterial Material=copper IsInternal
  FiniteCond2: Finite Conductivity Objects=Ground_Plate UseMaterial Material=copper IsInternal
  Rad1: Radiation Objects=Box1
  1: Lumped Port Objects=Rectangle13 LumpedPortType=Modal Modes{Mode1{IntLine{(-20, -5.5, 0) -> (-20, -5.5, 0.508)} CharImp=Zpi}} Impedance=50ohm
  2: Lumped Port Objects=Rectangle14 LumpedPortType=Modal Modes{Mode1{IntLine{(50, -5.5, 0) -> (50, -5.5, 0.508)} CharImp=Zpi}} Impedance=50ohm
setups:
  Setup1: HfssDriven Frequency=2.25GHz MaxDeltaS=0.02 MaximumPasses=6 MinimumPasses=1 MinimumConvergedPasses=1 PercentRefinement=30 BasisOrder=1 PortAccuracy=2 DrivenSolverType="Direct Solver"
    sweep Sweep: 2.24GHz to 2.26GHz, 401 points; Type=Interpolating InterpTolerance=0.5 InterpMaxSolns=250 PassivityErrorTolerance=0.0001
source amplitudes:
  1:1: 1V 0deg
  2:1: 0V 0deg
